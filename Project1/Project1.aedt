# Ansys Electronics Desktop project, version 2020.1
materials:
  vacuum: permittivity=1
  steel_1008: permeability{HUnit=A_per_meter BUnit=tesla curve (0, 0) (159.2, 0.2402) (318.3, 0.8654) (477.5, 1.1106) (636.6, 1.2458) (795.8, 1.331) (1591.5, 1.5) (3183.1, 1.6) (4774.6, 1.683) (6366.2, 1.741) (7957.7, 1.78) (15915.5, 1.905) (31831, 2.025) (47746.5, 2.085) (63662, 2.13) (79577.5, 2.165) (159155, 2.28) (318310, 2.485) (397887, 2.5851)} conductivity=2000000
  steel_1010: permittivity=1 permeability{HUnit=A_per_meter BUnit=tesla curve (0, 0) (238.7, 0.2003) (318.3, 0.3204) (358.1, 0.40045) (437.7, 0.50055) (477.5, 0.5606) (636.6, 0.7908) (795.8, 0.931) (1114.1, 1.1014) (1273.2, 1.2016) (1591.5, 1.302) (2228.2, 1.4028) (3183.1, 1.524) (4774.6, 1.626) (6366.2, 1.698) (7957.7, 1.73) (15915.5, 1.87) (31831, 1.99) (47746.5, 2.04) (63662, 2.07) (79577.5, 2.095) (159155, 2.2) (318310, 2.4)} conductivity=2000000 lande_g_factor=2
  copper: permeability=0.999991 conductivity=58000000
  iron: permeability=4000 conductivity=10300000

design Maxwell2DDesign1 (Maxwell 2D, Magnetostatic, XY geometry, model units mm)
variables:
  NumberOfTurns = 250
  CurrentValue = -3A
geometry:
  Polyline1 = polyline(z=0mm, xy in mm: (0, 0) (0, 70) (60, 70) (60, 55) (15, 55) (15, 15) (60, 15) (60, 0) (0, 0), closed, covered)
  point Point1 = (45mm, 55mm, 0mm)
  Polyline2 [iron] = polyline(z=0mm, xy in mm: (45, 55) (45, 15) (60, 15) (60, 55) (45, 55), closed, covered)
  Polyline2.unite(Polyline1)
  Circle1 = circle(normal=Z, centre=(52.5mm, 35mm, 0mm), radius=12.5mm)
  Polyline2.subtract(Circle1)
  point Point2 = (45mm, 44.5mm, 0mm)
  point Point3 = (45mm, 44.5mm, 0mm)
  Polyline8 [iron] = polyline(z=0mm, xy in mm: (45, 44.5) (52.6, 47) (60, 44.5) (60, 25.5) (52.5, 23) (45, 25.5) (45, 44.5), closed, covered, Arc from point 0 over 3, Arc from point 3 over 3)
  Circle2 = circle(normal=Z, centre=(52.5mm, 35mm, 0mm), radius=10mm)
  Polyline8.unite(Circle2)
  Rectangle1 [copper] = rectangle(corner=(15mm, 50mm, 0mm), x_size=10mm, y_size=-30mm)
  Rectangle2 = rectangle(corner=(-10mm, 50mm, 0mm), x_size=10mm, y_size=-30mm)
  Rectangle1.unite(Rectangle2)
  Circle3 [vacuum] = circle(normal=Z, centre=(30mm, 35mm, 0mm), radius=68.007353mm)
  Rectangle1_Separate1 [copper] = Rectangle1.separate_bodies()
  coordinate_system ObjectCS1 = object of Polyline8: Origin=centre of Polyline8.face(at (52.5, 35.0006, 0)) xAxis{xDirection=1 yDirection=0 zDirection=0} yAxis{xDirection=0 yDirection=1 zDirection=0}
  Polyline8.duplicate_around_axis(axis=Z, angle=90deg, total=1, attached) in ObjectCS1
  Polyline9 [non-model] = polyline((0mm, 34mm, 0mm) (15mm, 34mm, 0mm))
boundaries and excitations:
  VectorPotential1: Vector Potential Edges=Circle3.edge(1 of 1) Value=0
  Current1: Current Objects=Rectangle1 Current=NumberOfTurns*CurrentValue IsPositive=true
  Current2: Current Objects=Rectangle1_Separate1 Current=NumberOfTurns*CurrentValue IsPositive=false
parameters:
  Matrix1: Matrix Current1: NumberOfTurns=NumberOfTurns ReturnPath=Current2
mesh:
  initial mesh: MeshMethod=AnsoftTAU
setups:
  Setup1: Magnetostatic MaximumPasses=10 MinimumPasses=2 MinimumConvergedPasses=1 PercentRefinement=30 PercentError=1 ConstantDelta=0s NonLinearResidual=1e-07
field calculator expressions:
  flux = Mag_B | EnterLine(Polyline9) | LineValue | Integrate
  flux2 = Mag_B | EnterLine(Polyline9) | LineValue | Integrate
  CcoreEnergy = energy | EnterVolume(Polyline2) | VolumeValue | Integrate
  RotatingPart = energy | EnterVolume(Polyline8) | VolumeValue | Integrate
  Space = energy | EnterVolume(Circle3) | VolumeValue | Integrate
  Copper1 = energy | EnterVolume(Rectangle1) | VolumeValue | Integrate
  Copper2 = energy | EnterVolume(Rectangle1_Separate1) | VolumeValue | Integrate
  TotalEnergy = Copper2 | Copper1 | + | Space | RotatingPart | + | CcoreEnergy | + | +
field plots:
  B_Vector2: B over Polyline2, Rectangle1_Separate1, Rectangle1, Polyline8, Circle3 on Setup1 : LastAdaptive
  Mag_B1: B over Polyline8, Polyline2, Rectangle1, Rectangle1_Separate1, Circle3 on Setup1 : LastAdaptive
reports:
  Calculator Expressions Table 1: flux vs NumberOfTurns on Setup1 : LastAdaptive
  Calculator Expressions Table 2: TotalEnergy vs NumberOfTurns on Setup1 : LastAdaptive
