# Ansys Electronics Desktop project, version 2020.1
materials:
  vacuum: permittivity=1
  NdFe30: CoordinateSystemType=Cylindrical permittivity=1 permeability=1.044573 conductivity=625000 magnetic_coercivity{Magnitude=-838000A_per_meter DirComp1=1 DirComp2=0 DirComp3=0} lande_g_factor=2
  M19_29G: permeability{HUnit=A_per_meter BUnit=tesla curve (0, 0) (22.28, 0.05) (25.46, 0.1) (31.83, 0.15) (47.74, 0.36) (63.66, 0.54) (79.57, 0.65) (159.15, 0.99) (318.3, 1.2) (477.46, 1.28) (636.61, 1.33) (795.77, 1.36) (1591.5, 1.44) (3183, 1.52) (4774.6, 1.58) (6366.1, 1.63) (7957.7, 1.67) (15915, 1.8) (31830, 1.9) (111407, 2) (190984, 2.1) (350138, 2.3) (509292, 2.5)} conductivity=1960000 core_loss_type="Electrical Steel" core_loss_kh=164.2 core_loss_kc=0.409 mass_density=7650
  copper: permeability=0.999991 conductivity=58000000
  NdFe30_neg: CoordinateSystemType=Cylindrical permittivity=1 permeability=1.044573 conductivity=625000 magnetic_coercivity{Magnitude=-838000A_per_meter DirComp1=-1 DirComp2=0 DirComp3=0} lande_g_factor=2
  NdFe30_pos: CoordinateSystemType=Cylindrical permittivity=1 permeability=1.044573 conductivity=625000 magnetic_coercivity{Magnitude=-838000A_per_meter DirComp1=1 DirComp2=0 DirComp3=0} lande_g_factor=2

design 1_whole_motor (Maxwell 2D, Transient, XY geometry, model units mm)
options: ModelDepth=1meter
geometry:
  Stator [vacuum] = user_primitive(RMxprt/SlotCore.dll, DiaGap=161.9mm, DiaYoke=269.24mm, Length=0mm, Skew=0deg, Slots=24, SlotType=1, Hs0=1.03mm, Hs01=0mm, Hs1=1mm, Hs2=29.5mm, Bs0=1.93mm, Bs1=5mm, Bs2=8mm, Rs=5mm, FilletType=0, HalfSlot=0, SegAngle=0deg, LenRegion=200mm, InfoCore=0)
  Rotor [vacuum] = user_primitive(RMxprt/PMCore.dll, DiaGap=160.4mm, DiaYoke=110.64mm, Length=0mm, Poles=20, PoleType=3, Embrace=0.7, ThickMag=6.48mm, WidthMag=32mm, Offset=0mm, Bridge=5mm, Rib=1mm, LenRegion=200mm, InfoCore=0)
  Magnets [vacuum] = user_primitive(RMxprt/PMCore.dll, DiaGap=160.4mm, DiaYoke=110.64mm, Length=0mm, Poles=20, PoleType=3, Embrace=0.7, ThickMag=6.48mm, WidthMag=32mm, Offset=0mm, Bridge=5mm, Rib=1mm, LenRegion=200mm, InfoCore=1)
  PhaseA1 [vacuum] = user_primitive(RMxprt/LapCoil.dll, DiaGap=161.9mm, DiaYoke=269.24mm, Length=0mm, Skew=0deg, Slots=24, SlotType=2, Hs0=1.28mm, Hs1=0.1mm, Hs2=29.7mm, Bs0=2.11mm, Bs1=3.14mm, Bs2=5.65mm, Rs=2.5mm, FilletType=0, Layers=1, CoilPitch=1, EndExt=5mm, SpanExt=18mm, BendAngle=0deg, SegAngle=10deg, LenRegion=200mm, InfoCoil=1)
  PhaseC1, PhaseB1 [vacuum] = PhaseA1.duplicate_around_axis(axis=Z, angle=30deg, total=3)
  PhaseA1_1, PhaseA1_2, PhaseA1_3 [vacuum] = PhaseA1.duplicate_around_axis(axis=Z, angle=90deg, total=4)
  PhaseB1_1, PhaseB1_2, PhaseB1_3 [vacuum] = PhaseB1.duplicate_around_axis(axis=Z, angle=90deg, total=4)
  PhaseC1_1, PhaseC1_2, PhaseC1_3 [vacuum] = PhaseC1.duplicate_around_axis(axis=Z, angle=90deg, total=4)
mesh:
  initial mesh: MeshMethod=AnsoftTAU

design 2_partial_motor (Maxwell 2D, Transient, XY geometry, model units mm)
options: ModelDepth=1meter
geometry:
  Stator [M19_29G] = user_primitive(RMxprt/SlotCore.dll, DiaGap=161.9mm, DiaYoke=269.24mm, Length=0mm, Skew=0deg, Slots=24, SlotType=1, Hs0=1.03mm, Hs01=0mm, Hs1=1mm, Hs2=29.5mm, Bs0=1.93mm, Bs1=5mm, Bs2=8mm, Rs=5mm, FilletType=0, HalfSlot=0, SegAngle=0deg, LenRegion=200mm, InfoCore=0)
  Rotor [M19_29G] = user_primitive(RMxprt/PMCore.dll, DiaGap=160.4mm, DiaYoke=110.64mm, Length=0mm, Poles=20, PoleType=3, Embrace=0.7, ThickMag=6.48mm, WidthMag=32mm, Offset=0mm, Bridge=5mm, Rib=1mm, LenRegion=200mm, InfoCore=0)
  PM4 [vacuum] = user_primitive(RMxprt/PMCore.dll, DiaGap=160.4mm, DiaYoke=110.64mm, Length=0mm, Poles=20, PoleType=3, Embrace=0.7, ThickMag=6.48mm, WidthMag=32mm, Offset=0mm, Bridge=5mm, Rib=1mm, LenRegion=200mm, InfoCore=1)
  PhaseA1 [vacuum] = user_primitive(RMxprt/LapCoil.dll, DiaGap=161.9mm, DiaYoke=269.24mm, Length=0mm, Skew=0deg, Slots=24, SlotType=2, Hs0=1.28mm, Hs1=0.1mm, Hs2=29.7mm, Bs0=2.11mm, Bs1=3.14mm, Bs2=5.65mm, Rs=2.5mm, FilletType=0, Layers=1, CoilPitch=1, EndExt=5mm, SpanExt=18mm, BendAngle=0deg, SegAngle=10deg, LenRegion=200mm, InfoCoil=1)
  PhaseC1, PhaseB1 [vacuum] = PhaseA1.duplicate_around_axis(axis=Z, angle=30deg, total=3)
  [PM4, Stator, Rotor, PhaseA1, PhaseC1, PhaseB1].split(plane=ZX, keep=PositiveOnly)
  [PM4, Stator, Rotor, PhaseA1, PhaseC1, PhaseB1].split(plane=YZ, keep=PositiveOnly)
  Region [vacuum] = polyline((0mm, 0mm, 0mm) (200mm, 0mm, 0mm))
  Region.sweep_around_axis(axis=Z, angle=90deg, segments=10)
  PM2 [NdFe30, oriented by PM2_CS], PM3, PM5 [vacuum], PM1 [NdFe30, oriented by PM1_CS] = PM4.separate_bodies()
  coordinate_system PM1_CS = face of PM1: Origin=PM4.vertex(78 of 80) FaceID=PM4.face(at (76.2531, 12.0773, 0)) AxisPosn=PM4.vertex(79 of 80) WhichAxis=X ZRotationAngle=0deg XOffset=0mm YOffset=0mm
  coordinate_system PM2_CS = face of PM2: Origin=PM4.vertex(38 of 80) FaceID=PM4.face(at (68.7889, 35.0497, 0)) AxisPosn=PM4.vertex(39 of 80) WhichAxis=X ZRotationAngle=0deg XOffset=0mm YOffset=0mm
boundaries and excitations:
  Master1: Master Edges=Region.edge(1 of 1)
  Slave1: Slave Edges=Region.edge(#2284) ReverseU master=Master1 SameAsMaster=false
  Zero_Flux: Vector Potential Edges=Region.edge(#2283, #2282, #2281, #2280, #2279, #2278, #2277, #2276, #2275, #2274, #2273) Value=0
mesh:
  initial mesh: MeshMethod=AnsoftTAU

design 3_partial_motor_MS (Maxwell 2D, Magnetostatic, XY geometry, model units mm)
geometry:
  Stator [M19_29G] = user_primitive(RMxprt/SlotCore.dll, DiaGap=161.9mm, DiaYoke=269.24mm, Length=0mm, Skew=0deg, Slots=24, SlotType=1, Hs0=1.03mm, Hs01=0mm, Hs1=1mm, Hs2=29.5mm, Bs0=1.93mm, Bs1=5mm, Bs2=8mm, Rs=5mm, FilletType=0, HalfSlot=0, SegAngle=0deg, LenRegion=200mm, InfoCore=0)
  Rotor [M19_29G] = user_primitive(RMxprt/PMCore.dll, DiaGap=160.4mm, DiaYoke=110.64mm, Length=0mm, Poles=20, PoleType=3, Embrace=0.7, ThickMag=6.48mm, WidthMag=32mm, Offset=0mm, Bridge=5mm, Rib=1mm, LenRegion=200mm, InfoCore=0)
  PM4 [vacuum] = user_primitive(RMxprt/PMCore.dll, DiaGap=160.4mm, DiaYoke=110.64mm, Length=0mm, Poles=20, PoleType=3, Embrace=0.7, ThickMag=6.48mm, WidthMag=32mm, Offset=0mm, Bridge=5mm, Rib=1mm, LenRegion=200mm, InfoCore=1)
  PhaseA1 [vacuum] = user_primitive(RMxprt/LapCoil.dll, DiaGap=161.9mm, DiaYoke=269.24mm, Length=0mm, Skew=0deg, Slots=24, SlotType=2, Hs0=1.28mm, Hs1=0.1mm, Hs2=29.7mm, Bs0=2.11mm, Bs1=3.14mm, Bs2=5.65mm, Rs=2.5mm, FilletType=0, Layers=1, CoilPitch=1, EndExt=5mm, SpanExt=18mm, BendAngle=0deg, SegAngle=10deg, LenRegion=200mm, InfoCoil=1)
  PhaseC1, PhaseB1 [vacuum] = PhaseA1.duplicate_around_axis(axis=Z, angle=30deg, total=3)
  [PM4, Stator, Rotor, PhaseA1, PhaseC1, PhaseB1].split(plane=ZX, keep=PositiveOnly)
  [PM4, Stator, Rotor, PhaseA1, PhaseC1, PhaseB1].split(plane=YZ, keep=PositiveOnly)
  Region [vacuum] = polyline((0mm, 0mm, 0mm) (200mm, 0mm, 0mm))
  Region.sweep_around_axis(axis=Z, angle=90deg, segments=10)
  PM2 [NdFe30, oriented by PM2_CS], PM3, PM5 [vacuum], PM1 [NdFe30, oriented by PM1_CS] = PM4.separate_bodies()
  coordinate_system PM1_CS = face of PM1: Origin=PM4.vertex(78 of 80) FaceID=PM4.face(at (76.2531, 12.0773, 0)) AxisPosn=PM4.vertex(79 of 80) WhichAxis=X ZRotationAngle=0deg XOffset=0mm YOffset=0mm
  coordinate_system PM2_CS = face of PM2: Origin=PM4.vertex(38 of 80) FaceID=PM4.face(at (68.7889, 35.0497, 0)) AxisPosn=PM4.vertex(39 of 80) WhichAxis=X ZRotationAngle=0deg XOffset=0mm YOffset=0mm
boundaries and excitations:
  Master1: Master Edges=Region.edge(1 of 1)
  Slave1: Slave Edges=Region.edge(#2284) ReverseU master=Master1 SameAsMaster=false
  Zero_Flux: Vector Potential Edges=Region.edge(#2283, #2282, #2281, #2280, #2279, #2278, #2277, #2276, #2275, #2274, #2273) Value=0
parameters:
  Torque1: Torque Coordinate_System=Global Is_Positive=true Objects=[PM1, PM2, Rotor]
mesh:
  Rotor: LengthBased RefineInside Objects=Rotor MaxLength=5mm
  Length1: LengthBased RefineInside Objects=[PM1, PM2] MaxLength=3mm
  SurfApprox1: SurfApproxBased Objects=Stator CurvedSurfaceApproxChoice=UseSlider SliderMeshSettings=6
  initial mesh: MeshMethod=AnsoftTAU
setups:
  Setup1: Magnetostatic MaximumPasses=10 MinimumPasses=2 MinimumConvergedPasses=1 PercentRefinement=15 PercentError=0.1 NonLinearResidual=0.0001

design 4_partial_motor_MS2 (Maxwell 2D, Magnetostatic, XY geometry, model units mm)
geometry:
  Stator [M19_29G] = user_primitive(RMxprt/SlotCore.dll, DiaGap=161.9mm, DiaYoke=269.24mm, Length=0mm, Skew=0deg, Slots=24, SlotType=1, Hs0=1.03mm, Hs01=0mm, Hs1=1mm, Hs2=29.5mm, Bs0=1.93mm, Bs1=5mm, Bs2=8mm, Rs=5mm, FilletType=0, HalfSlot=0, SegAngle=0deg, LenRegion=200mm, InfoCore=0)
  Rotor [M19_29G] = user_primitive(RMxprt/PMCore.dll, DiaGap=160.4mm, DiaYoke=110.64mm, Length=0mm, Poles=20, PoleType=3, Embrace=0.7, ThickMag=6.48mm, WidthMag=32mm, Offset=0mm, Bridge=5mm, Rib=1mm, LenRegion=200mm, InfoCore=0)
  PM4 [vacuum] = user_primitive(RMxprt/PMCore.dll, DiaGap=160.4mm, DiaYoke=110.64mm, Length=0mm, Poles=20, PoleType=3, Embrace=0.7, ThickMag=6.48mm, WidthMag=32mm, Offset=0mm, Bridge=5mm, Rib=1mm, LenRegion=200mm, InfoCore=1)
  PhaseA1_neg [copper] = user_primitive(RMxprt/LapCoil.dll, DiaGap=161.9mm, DiaYoke=269.24mm, Length=0mm, Skew=0deg, Slots=24, SlotType=2, Hs0=1.28mm, Hs1=0.1mm, Hs2=29.7mm, Bs0=2.11mm, Bs1=3.14mm, Bs2=5.65mm, Rs=2.5mm, FilletType=0, Layers=1, CoilPitch=1, EndExt=5mm, SpanExt=18mm, BendAngle=0deg, SegAngle=10deg, LenRegion=200mm, InfoCoil=1)
  PhaseC1_pos, PhaseB1_neg [copper] = PhaseA1_neg.duplicate_around_axis(axis=Z, angle=30deg, total=3)
  [PM4, Stator, Rotor, PhaseA1_neg, PhaseC1_pos, PhaseB1_neg].split(plane=ZX, keep=PositiveOnly)
  [PM4, Stator, Rotor, PhaseA1_neg, PhaseC1_pos, PhaseB1_neg].split(plane=YZ, keep=PositiveOnly)
  Region [vacuum] = polyline((0mm, 0mm, 0mm) (200mm, 0mm, 0mm))
  Region.sweep_around_axis(axis=Z, angle=90deg, segments=10)
  PM2 [NdFe30, oriented by PM2_CS], PM3, PM5 [vacuum], PM1 [NdFe30, oriented by PM1_CS] = PM4.separate_bodies()
  coordinate_system PM1_CS = face of PM1: Origin=PM4.vertex(78 of 80) FaceID=PM4.face(at (76.2531, 12.0773, 0)) AxisPosn=PM4.vertex(79 of 80) WhichAxis=X ZRotationAngle=0deg XOffset=0mm YOffset=0mm
  coordinate_system PM2_CS = face of PM2: Origin=PM4.vertex(38 of 80) FaceID=PM4.face(at (68.7889, 35.0497, 0)) AxisPosn=PM4.vertex(39 of 80) WhichAxis=X ZRotationAngle=0deg XOffset=0mm YOffset=0mm
  PhaseA1_pos [copper] = PhaseA1_neg.separate_bodies()
  PhaseC1_neg [copper] = PhaseC1_pos.separate_bodies()
  PhaseB1_pos [copper] = PhaseB1_neg.separate_bodies()
boundaries and excitations:
  Master1: Master Edges=Region.edge(1 of 1)
  Slave1: Slave Edges=Region.edge(#2284) ReverseU master=Master1 SameAsMaster=false
  Zero_Flux: Vector Potential Edges=Region.edge(#2283, #2282, #2281, #2280, #2279, #2278, #2277, #2276, #2275, #2274, #2273) Value=0
  phasea_pos: Current Objects=PhaseA1_pos Current=500A IsPositive=true
  phasea_neg: Current Objects=PhaseA1_neg Current=500A IsPositive=false
  phasec_pos: Current Objects=PhaseC1_pos Current=-250A IsPositive=true
  phasec_neg: Current Objects=PhaseC1_neg Current=-250A IsPositive=false
  phaseb_neg: Current Objects=PhaseB1_neg Current=-250A IsPositive=false
  phaseb_pos: Current Objects=PhaseB1_pos Current=-250A IsPositive=true
parameters:
  Torque1: Torque Coordinate_System=Global Is_Positive=true Objects=[PM1, PM2, Rotor]
  Matrix1: Matrix phasea_neg, phasea_pos, phaseb_neg, phaseb_pos, phasec_neg, phasec_pos: NumberOfTurns=9; group phasea = phasea_neg, phasea_pos (1 parallel); group phaseb = phasec_neg, phasec_pos (1 parallel); group phasec = phaseb_neg, phaseb_pos (1 parallel)
mesh:
  Rotor: LengthBased RefineInside Objects=Rotor MaxLength=5mm
  Length1: LengthBased RefineInside Objects=[PM1, PM2] MaxLength=3mm
  SurfApprox1: SurfApproxBased Objects=Stator CurvedSurfaceApproxChoice=UseSlider SliderMeshSettings=6
  initial mesh: MeshMethod=AnsoftTAU
setups:
  Setup1: Magnetostatic MaximumPasses=10 MinimumPasses=2 MinimumConvergedPasses=1 PercentRefinement=15 PercentError=0.1 NonLinearResidual=0.0001

design 5_partial_motor_TR_wrong (Maxwell 2D, Transient, XY geometry, model units mm)
options: ModelDepth=83.82mm
variables:
  Poles = 20
  PolePairs = Poles/2
  Speed_rpm = 500
  Omega = 360*Speed_rpm*PolePairs/60
  Omega_rad = Omega*pi/180
  Thet_deg = 20
  Thet = Thet_deg*pi/180
  Imax = 0A
geometry:
  Stator [M19_29G] = user_primitive(RMxprt/SlotCore.dll, DiaGap=161.9mm, DiaYoke=269.24mm, Length=0mm, Skew=0deg, Slots=24, SlotType=1, Hs0=1.03mm, Hs01=0mm, Hs1=1mm, Hs2=29.5mm, Bs0=1.93mm, Bs1=5mm, Bs2=8mm, Rs=5mm, FilletType=0, HalfSlot=0, SegAngle=0deg, LenRegion=200mm, InfoCore=0)
  Rotor [M19_29G] = user_primitive(RMxprt/PMCore.dll, DiaGap=160.4mm, DiaYoke=110.64mm, Length=0mm, Poles=20, PoleType=3, Embrace=0.7, ThickMag=6.48mm, WidthMag=32mm, Offset=0mm, Bridge=5mm, Rib=1mm, LenRegion=200mm, InfoCore=0)
  PM4 [NdFe30_neg] = user_primitive(RMxprt/PMCore.dll, DiaGap=160.4mm, DiaYoke=110.64mm, Length=0mm, Poles=20, PoleType=3, Embrace=0.7, ThickMag=6.48mm, WidthMag=32mm, Offset=0mm, Bridge=5mm, Rib=1mm, LenRegion=200mm, InfoCore=1)
  PhaseA1_neg [vacuum] = user_primitive(RMxprt/LapCoil.dll, DiaGap=161.9mm, DiaYoke=269.24mm, Length=0mm, Skew=0deg, Slots=24, SlotType=2, Hs0=1.28mm, Hs1=0.1mm, Hs2=29.7mm, Bs0=2.11mm, Bs1=3.14mm, Bs2=5.65mm, Rs=2.5mm, FilletType=0, Layers=1, CoilPitch=1, EndExt=5mm, SpanExt=18mm, BendAngle=0deg, SegAngle=10deg, LenRegion=200mm, InfoCoil=1)
  PhaseC1_pos, PhaseB1_neg [vacuum] = PhaseA1_neg.duplicate_around_axis(axis=Z, angle=30deg, total=3)
  [PM4, Stator, Rotor, PhaseA1_neg, PhaseC1_pos, PhaseB1_neg].split(plane=ZX, keep=PositiveOnly)
  [PM4, Stator, Rotor, PhaseA1_neg, PhaseC1_pos, PhaseB1_neg].split(plane=YZ, keep=PositiveOnly)
  Region [vacuum] = polyline((0mm, 0mm, 0mm) (200mm, 0mm, 0mm))
  Region.sweep_around_axis(axis=Z, angle=90deg, segments=10)
  PM2 [NdFe30_neg, oriented by PM2_CS], PM3, PM5 [NdFe30_pos], PM1 [NdFe30_pos, oriented by PM1_CS] = PM4.separate_bodies()
  coordinate_system PM1_CS = face of PM1: Origin=PM4.vertex(78 of 80) FaceID=PM4.face(at (76.2531, 12.0773, 0)) AxisPosn=PM4.vertex(79 of 80) WhichAxis=X ZRotationAngle=0deg XOffset=0mm YOffset=0mm
  coordinate_system PM2_CS = face of PM2: Origin=PM4.vertex(38 of 80) FaceID=PM4.face(at (68.7889, 35.0497, 0)) AxisPosn=PM4.vertex(39 of 80) WhichAxis=X ZRotationAngle=0deg XOffset=0mm YOffset=0mm
  PhaseA1_pos [vacuum] = PhaseA1_neg.separate_bodies()
  PhaseC1_neg [vacuum] = PhaseC1_pos.separate_bodies()
  PhaseB1_pos [vacuum] = PhaseB1_neg.separate_bodies()
  Band [vacuum] = polyline((0mm, 0mm, 0mm) (80.575mm, 0mm, 0mm))
  Band.sweep_around_axis(axis=Z, angle=90deg)
  Band_in [vacuum] = polyline((0mm, 0mm, 0mm) (80.4mm, 0mm, 0mm))
  Band_in.sweep_around_axis(axis=Z, angle=90deg)
motion:
  MotionSetup1: Band Move_Type=Rotate Coordinate_System=Global Axis=Z Is_Positive=true InitPos=0deg Angular_Velocity=500rpm Objects=Band
  Moving1: Moving Objects=[Rotor, PM4, PM2, PM3, PM5, PM1, Band_in]
boundaries and excitations:
  Master1: Master Edges=Region.edge(1 of 1)
  Slave1: Slave Edges=Region.edge(#2284) ReverseU master=Master1 SameAsMaster=false
  Zero_Flux: Vector Potential Edges=Region.edge(#2283, #2282, #2281, #2280, #2279, #2278, #2277, #2276, #2275, #2274, #2273) Value=0
  PhaseA1_neg: Coil Objects=PhaseA1_neg Conductor_number=9 Winding=Phase_A PolarityType=Negative
  PhaseA1_pos: Coil Objects=PhaseA1_pos Conductor_number=9 Winding=Phase_A PolarityType=Positive
  PhaseB1_neg: Coil Objects=PhaseB1_neg Conductor_number=9 Winding=Phase_B PolarityType=Negative
  PhaseC1_neg: Coil Objects=PhaseC1_neg Conductor_number=9 Winding=Phase_C PolarityType=Negative
  PhaseC1_pos: Coil Objects=PhaseC1_pos Conductor_number=9 Winding=Phase_C PolarityType=Positive
  PhaseB1_pos: Coil Objects=PhaseB1_pos Conductor_number=9 Winding=Phase_B PolarityType=Positive
  Phase_A: Winding Group Type=Current IsSolid=false Current=Imax*sin(Omega_rad*Time+Thet) ParallelBranchesNum=1
  Phase_B: Winding Group Type=Current IsSolid=false Current=Imax*sin(Omega_rad*Time+Thet-2*pi/3) ParallelBranchesNum=1
  Phase_C: Winding Group Type=Current IsSolid=false Current=Imax*sin(Omega_rad*Time+Thet-4*pi/2) ParallelBranchesNum=1
  core loss on: Stator, Rotor
mesh:
  Coils: LengthBased RefineInside Objects=[PhaseA1_neg, PhaseA1_pos, PhaseB1_neg, PhaseB1_pos, PhaseC1_neg, PhaseC1_pos] MaxLength=4mm
  Magnets: LengthBased RefineInside Objects=[PM1, PM2] MaxLength=3mm
  Rotor: LengthBased RefineInside Objects=Rotor MaxLength=4mm
  Stator: LengthBased RefineInside Objects=Stator MaxLength=2mm
  initial mesh: MeshMethod=AnsoftTAU
setups:
  Setup1: Transient NonlinearSolverResidual=1e-06 StopTime=200ms TimeStep=50us SaveFieldsType=Custom SweepRanges{0ms to 15ms step 250us point 100ms point 200ms} NumberSolveSteps=1 RangeStart=0s RangeEnd=0.1s InitialTimeStep=0.002s MinTimeStep=0.001s MaxTimeStep=0.003s TimeStepErrTolerance=0.0001
reports:
  Torque: Moving1.LoadTorque, Moving1.Torque vs Time on Setup1 : Transient [Poles=all Speed_rpm=all Thet_deg=all Imax=all]
  Speed: Moving1.Speed vs Time on Setup1 : Transient [Poles=all Speed_rpm=all Thet_deg=all Imax=all]
  Winding Plot 1: InducedVoltage(Phase_A), InducedVoltage(Phase_B), InducedVoltage(Phase_C) vs Time on Setup1 : Transient

design 2_partial_half (Maxwell 2D, Transient, XY geometry, model units mm)
options: ModelDepth=83.82mm
variables:
  Poles = 20
  PolePairs = Poles/2
  Speed_rpm = 500
  Omega = 360*Speed_rpm*PolePairs/60
  Omega_rad = Omega*pi/180
  Thet_deg = 20
  Thet = Thet_deg*pi/180
  Imax = 0A
geometry:
  Stator [M19_29G] = user_primitive(RMxprt/SlotCore.dll, DiaGap=161.9mm, DiaYoke=269.24mm, Length=0mm, Skew=0deg, Slots=24, SlotType=1, Hs0=1.03mm, Hs01=0mm, Hs1=1mm, Hs2=29.5mm, Bs0=1.93mm, Bs1=5mm, Bs2=8mm, Rs=5mm, FilletType=0, HalfSlot=0, SegAngle=0deg, LenRegion=200mm, InfoCore=0)
  Rotor [M19_29G] = user_primitive(RMxprt/PMCore.dll, DiaGap=160.4mm, DiaYoke=110.64mm, Length=0mm, Poles=20, PoleType=3, Embrace=0.7, ThickMag=6.48mm, WidthMag=32mm, Offset=0mm, Bridge=5mm, Rib=1mm, LenRegion=200mm, InfoCore=0)
  PM1 [NdFe30_pos] = user_primitive(RMxprt/PMCore.dll, DiaGap=160.4mm, DiaYoke=110.64mm, Length=0mm, Poles=20, PoleType=3, Embrace=0.7, ThickMag=6.48mm, WidthMag=32mm, Offset=0mm, Bridge=5mm, Rib=1mm, LenRegion=200mm, InfoCore=1)
  PhaseA1_pos [copper] = user_primitive(RMxprt/LapCoil.dll, DiaGap=161.9mm, DiaYoke=269.24mm, Length=0mm, Skew=0deg, Slots=24, SlotType=2, Hs0=1.28mm, Hs1=0.1mm, Hs2=29.7mm, Bs0=2.11mm, Bs1=3.14mm, Bs2=5.65mm, Rs=2.5mm, FilletType=0, Layers=1, CoilPitch=1, EndExt=5mm, SpanExt=18mm, BendAngle=0deg, SegAngle=10deg, LenRegion=200mm, InfoCoil=1)
  PhaseC1_neg, PhaseB1_pos [copper] = PhaseA1_pos.duplicate_around_axis(axis=Z, angle=30deg, total=3)
  PhaseA3_neg [copper] = PhaseA1_pos.duplicate_around_axis(axis=Z, angle=90deg, total=4)  # copies kept: 1
  PhaseB3_neg [copper] = PhaseB1_pos.duplicate_around_axis(axis=Z, angle=90deg, total=4)  # copies kept: 1
  PhaseC3_pos [copper] = PhaseC1_neg.duplicate_around_axis(axis=Z, angle=90deg, total=4)  # copies kept: 1
  [Stator, Rotor, PM1, PhaseA1_pos, PhaseC1_neg, PhaseB1_pos, PhaseA3_neg, PhaseB3_neg, PhaseC3_pos].split(plane=ZX, keep=PositiveOnly)
  PhaseA1_neg [copper] = PhaseA1_pos.separate_bodies()
  PhaseA3_pos [copper] = PhaseA3_neg.separate_bodies()
  PhaseB1_neg [copper] = PhaseB1_pos.separate_bodies()
  PhaseB3_pos [copper] = PhaseB3_neg.separate_bodies()
  PhaseC1_pos [copper] = PhaseC1_neg.separate_bodies()
  PhaseC3_neg [copper] = PhaseC3_pos.separate_bodies()
  Region [vacuum] = polyline((0mm, 0mm, 0mm) (200mm, 0mm, 0mm))
  Region.sweep_around_axis(axis=Z, angle=180deg, segments=20)
  PM9, PM7, PM5, PM3 [NdFe30_pos], PM2, PM4, PM6, PM8, PM10 [NdFe30_neg] = PM1.separate_bodies()
  Polyline1 = polyline((0mm, 0mm, 0mm) (200mm, 0mm, 0mm))
  Polyline2 = polyline((0mm, 0mm, 0mm) (-200mm, 0mm, 0mm))
  Band [vacuum] = polyline((0mm, 0mm, 0mm) (80.575mm, 0mm, 0mm))
  Band.sweep_around_axis(axis=Z, angle=180deg)
  Band_in [vacuum] = polyline((0mm, 0mm, 0mm) (80.4mm, 0mm, 0mm))
  Band_in.sweep_around_axis(axis=Z, angle=180deg)
motion:
  MotionSetup1: Band Move_Type=Rotate Coordinate_System=Global Axis=Z Is_Positive=true InitPos=-90deg Angular_Velocity=500rpm Objects=Band
  Moving1: Moving Objects=[Rotor, PM1, PM9, PM7, PM5, PM3, PM2, PM4, PM6, PM8, PM10, Band_in]
boundaries and excitations:
  Master1: Master Edges=Polyline1.edge(1 of 1)
  Slave1: Slave Edges=Polyline2.edge(1 of 1) master=Master1 SameAsMaster=false
  VectorPotential1: Vector Potential Edges=Region.edge(#2305, #2304, #2303, #2302, #2301, #2299, #2300, #2290, #2291, #2292, #2293, #2294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) Value=0
  PhaseA1_neg: Coil Objects=PhaseA1_neg Conductor_number=9 Winding=PhaseA PolarityType=Negative
  PhaseA1_pos: Coil Objects=PhaseA1_pos Conductor_number=9 Winding=PhaseA PolarityType=Positive
  PhaseA3_neg: Coil Objects=PhaseA3_neg Conductor_number=9 Winding=PhaseA PolarityType=Negative
  PhaseA3_pos: Coil Objects=PhaseA3_pos Conductor_number=9 Winding=PhaseA PolarityType=Positive
  PhaseB1_neg: Coil Objects=PhaseB1_neg Conductor_number=9 Winding=PhaseB PolarityType=Negative
  PhaseB1_pos: Coil Objects=PhaseB1_pos Conductor_number=9 Winding=PhaseB PolarityType=Positive
  PhaseB3_neg: Coil Objects=PhaseB3_neg Conductor_number=9 Winding=PhaseB PolarityType=Negative
  PhaseB3_pos: Coil Objects=PhaseB3_pos Conductor_number=9 Winding=PhaseB PolarityType=Positive
  PhaseC1_neg: Coil Objects=PhaseC1_neg Conductor_number=9 Winding=PhaseC PolarityType=Negative
  PhaseC1_pos: Coil Objects=PhaseC1_pos Conductor_number=9 Winding=PhaseC PolarityType=Positive
  PhaseC3_neg: Coil Objects=PhaseC3_neg Conductor_number=9 Winding=PhaseC PolarityType=Negative
  PhaseC3_pos: Coil Objects=PhaseC3_pos Conductor_number=9 Winding=PhaseC PolarityType=Positive
  PhaseA: Winding Group Type=Current IsSolid=false Current=Imax*sin(Omega_rad*Time+Thet) ParallelBranchesNum=1
  PhaseB: Winding Group Type=Current IsSolid=false Current=Imax*sin(Omega_rad*Time+Thet-2*pi/3) ParallelBranchesNum=1
  PhaseC: Winding Group Type=Current IsSolid=false Current=Imax*sin(Omega_rad*Time+Thet-4*pi/3) ParallelBranchesNum=1
  core loss on: Stator, Rotor
mesh:
  Coils: LengthBased RefineInside Objects=[PhaseA1_neg, PhaseA1_pos, PhaseA3_neg, PhaseA3_pos, PhaseB1_neg, PhaseB1_pos, PhaseB3_neg, PhaseB3_pos, PhaseC1_neg, PhaseC1_pos, PhaseC3_neg, PhaseC3_pos] MaxLength=4mm
  Magnets_neg: LengthBased RefineInside Objects=[PM2, PM4, PM6, PM8, PM10] MaxLength=3mm
  Magnets_pos: LengthBased RefineInside Objects=[PM1, PM3, PM5, PM7, PM9] MaxLength=3mm
  Rotor: LengthBased RefineInside Objects=Rotor MaxLength=4mm
  Stator: LengthBased RefineInside Objects=Stator MaxLength=4mm
  initial mesh: MeshMethod=AnsoftTAU
setups:
  Setup1: Transient NonlinearSolverResidual=1e-06 StopTime=200ms TimeStep=50us SaveFieldsType=Custom SweepRanges{0ms to 100ms step 100us point 1000ms point 200ms} NumberSolveSteps=1 RangeStart=0s RangeEnd=0.1s InitialTimeStep=0.002s MinTimeStep=0.001s MaxTimeStep=0.003s TimeStepErrTolerance=0.0001
field plots:
  Mag_B1: B over PhaseA1_neg, PhaseA1_pos, PhaseA3_neg, PhaseA3_pos, PhaseB1_neg, PhaseB1_pos, PhaseB3_neg, PhaseB3_pos, PhaseC1_neg, PhaseC1_pos, PhaseC3_neg, PhaseC3_pos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 on Setup1 : Transient at Time=0ns
reports:
  Winding Plot 1: InducedVoltage(PhaseA), InducedVoltage(PhaseB), InducedVoltage(PhaseC) vs Time on Setup1 : Transient
  Position Plot 1: Moving1.Position vs Time on Setup1 : Transient

design 1_whole_motor_TR (Maxwell 2D, Transient, XY geometry, model units mm)
options: ModelDepth=83.82mm
variables:
  Poles = 20
  PolePairs = Poles/2
  Speed_rpm = 500
  Omega = 360*Speed_rpm*PolePairs/60
  Omega_rad = Omega*pi/180
  Thet_deg = 20
  Thet = Thet_deg*pi/180
  Imax = 0
geometry:
  Stator [M19_29G] = user_primitive(RMxprt/SlotCore.dll, DiaGap=161.9mm, DiaYoke=269.24mm, Length=0mm, Skew=0deg, Slots=24, SlotType=1, Hs0=1.03mm, Hs01=0mm, Hs1=1mm, Hs2=29.5mm, Bs0=1.93mm, Bs1=5mm, Bs2=8mm, Rs=5mm, FilletType=0, HalfSlot=0, SegAngle=0deg, LenRegion=200mm, InfoCore=0)
  Rotor [M19_29G] = user_primitive(RMxprt/PMCore.dll, DiaGap=160.4mm, DiaYoke=110.64mm, Length=0mm, Poles=20, PoleType=3, Embrace=0.7, ThickMag=6.48mm, WidthMag=32mm, Offset=0mm, Bridge=5mm, Rib=1mm, LenRegion=200mm, InfoCore=0)
  PM20 [NdFe30_neg] = user_primitive(RMxprt/PMCore.dll, DiaGap=160.4mm, DiaYoke=110.64mm, Length=0mm, Poles=20, PoleType=3, Embrace=0.7, ThickMag=6.48mm, WidthMag=32mm, Offset=0mm, Bridge=5mm, Rib=1mm, LenRegion=200mm, InfoCore=1)
  PhaseA1_neg [copper] = user_primitive(RMxprt/LapCoil.dll, DiaGap=161.9mm, DiaYoke=269.24mm, Length=0mm, Skew=0deg, Slots=24, SlotType=2, Hs0=1.28mm, Hs1=0.1mm, Hs2=29.7mm, Bs0=2.11mm, Bs1=3.14mm, Bs2=5.65mm, Rs=2.5mm, FilletType=0, Layers=1, CoilPitch=1, EndExt=5mm, SpanExt=18mm, BendAngle=0deg, SegAngle=10deg, LenRegion=200mm, InfoCoil=1)
  PhaseC1_pos, PhaseB1_neg [copper] = PhaseA1_neg.duplicate_around_axis(axis=Z, angle=30deg, total=3)
  PhaseA3_pos, PhaseA2_neg, PhaseA4_pos [copper] = PhaseA1_neg.duplicate_around_axis(axis=Z, angle=90deg, total=4)
  PhaseB3_pos, PhaseB2_neg, PhaseB4_pos [copper] = PhaseB1_neg.duplicate_around_axis(axis=Z, angle=90deg, total=4)
  PhaseC3_neg, PhaseC2_pos, PhaseC4_neg [copper] = PhaseC1_pos.duplicate_around_axis(axis=Z, angle=90deg, total=4)
  PhaseA1_pos [copper] = PhaseA1_neg.separate_bodies()
  PhaseA3_neg [copper] = PhaseA3_pos.separate_bodies()
  PhaseA2_pos [copper] = PhaseA2_neg.separate_bodies()
  PhaseA4_neg [copper] = PhaseA4_pos.separate_bodies()
  PhaseB1_pos [copper] = PhaseB1_neg.separate_bodies()
  PhaseB3_neg [copper] = PhaseB3_pos.separate_bodies()
  PhaseB2_pos [copper] = PhaseB2_neg.separate_bodies()
  PhaseB4_neg [copper] = PhaseB4_pos.separate_bodies()
  PhaseC1_neg [copper] = PhaseC1_pos.separate_bodies()
  PhaseC3_pos [copper] = PhaseC3_neg.separate_bodies()
  PhaseC2_neg [copper] = PhaseC2_pos.separate_bodies()
  PhaseC4_pos [copper] = PhaseC4_neg.separate_bodies()
  PM18, PM16, PM14, PM12, PM10, PM8, PM6, PM4, PM2 [NdFe30_neg], PM3, PM5, PM7, PM9, PM11, PM13, PM15, PM17, PM19, PM1 [NdFe30_pos] = PM20.separate_bodies()
  Region [vacuum] = polyline((0mm, 0mm, 0mm) (200mm, 0mm, 0mm))
  Region.sweep_around_axis(axis=Z, angle=360deg)
  Band [vacuum] = polyline((0mm, 0mm, 0mm) (80.575mm, 0mm, 0mm))
  Band.sweep_around_axis(axis=Z, angle=360deg)
  Band_in [vacuum] = polyline((0mm, 0mm, 0mm) (80.4mm, 0mm, 0mm))
  Band_in.sweep_around_axis(axis=Z, angle=360deg)
  Circle1 [non-model] = circle(normal=Z, centre=(0mm, 0mm, 0mm), radius=80.575mm, uncovered)
motion:
  MotionSetup1: Band Move_Type=Rotate Coordinate_System=Global Axis=Z Is_Positive=true InitPos=30deg Angular_Velocity=500rpm Objects=Band
  Moving1: Moving Objects=[Rotor, PM20, PM18, PM16, PM14, PM12, PM10, PM8, PM6, PM4, PM2, PM3, PM5, PM7, PM9, PM11, PM13, PM15, PM17, PM19, PM1, Band_in]
boundaries and excitations:
  Zero_Flux: Vector Potential Edges=Region.edge(#2235) Value=0
  PhaseA1_neg: Coil Objects=PhaseA1_neg Conductor_number=9 Winding=PhaseA PolarityType=Negative
  PhaseA1_pos: Coil Objects=PhaseA1_pos Conductor_number=9 Winding=PhaseA PolarityType=Positive
  PhaseA2_neg: Coil Objects=PhaseA2_neg Conductor_number=9 Winding=PhaseA PolarityType=Negative
  PhaseA2_pos: Coil Objects=PhaseA2_pos Conductor_number=9 Winding=PhaseA PolarityType=Positive
  PhaseA3_neg: Coil Objects=PhaseA3_neg Conductor_number=9 Winding=PhaseA PolarityType=Negative
  PhaseA3_pos: Coil Objects=PhaseA3_pos Conductor_number=9 Winding=PhaseA PolarityType=Positive
  PhaseA4_neg: Coil Objects=PhaseA4_neg Conductor_number=9 Winding=PhaseA PolarityType=Negative
  PhaseA4_pos: Coil Objects=PhaseA4_pos Conductor_number=9 Winding=PhaseA PolarityType=Positive
  PhaseB1_neg: Coil Objects=PhaseB1_neg Conductor_number=9 Winding=PhaseB PolarityType=Negative
  PhaseB1_pos: Coil Objects=PhaseB1_pos Conductor_number=9 Winding=PhaseB PolarityType=Positive
  PhaseB2_neg: Coil Objects=PhaseB2_neg Conductor_number=9 Winding=PhaseB PolarityType=Negative
  PhaseB2_pos: Coil Objects=PhaseB2_pos Conductor_number=9 Winding=PhaseB PolarityType=Positive
  PhaseB3_neg: Coil Objects=PhaseB3_neg Conductor_number=9 Winding=PhaseB PolarityType=Negative
  PhaseB3_pos: Coil Objects=PhaseB3_pos Conductor_number=9 Winding=PhaseB PolarityType=Positive
  PhaseB4_neg: Coil Objects=PhaseB4_neg Conductor_number=9 Winding=PhaseB PolarityType=Negative
  PhaseB4_pos: Coil Objects=PhaseB4_pos Conductor_number=9 Winding=PhaseB PolarityType=Positive
  PhaseC1_neg: Coil Objects=PhaseC1_neg Conductor_number=9 Winding=PhaseC PolarityType=Negative
  PhaseC1_pos: Coil Objects=PhaseC1_pos Conductor_number=9 Winding=PhaseC PolarityType=Positive
  PhaseC2_neg: Coil Objects=PhaseC2_neg Conductor_number=9 Winding=PhaseC PolarityType=Negative
  PhaseC2_pos: Coil Objects=PhaseC2_pos Conductor_number=9 Winding=PhaseC PolarityType=Positive
  PhaseC3_neg: Coil Objects=PhaseC3_neg Conductor_number=9 Winding=PhaseC PolarityType=Negative
  PhaseC3_pos: Coil Objects=PhaseC3_pos Conductor_number=9 Winding=PhaseC PolarityType=Positive
  PhaseC4_neg: Coil Objects=PhaseC4_neg Conductor_number=9 Winding=PhaseC PolarityType=Negative
  PhaseC4_pos: Coil Objects=PhaseC4_pos Conductor_number=9 Winding=PhaseC PolarityType=Positive
  PhaseA: Winding Group Type=Current IsSolid=false Current=Imax*sin(Omega_rad*Time+Thet) ParallelBranchesNum=1
  PhaseB: Winding Group Type=Current IsSolid=false Current=Imax*sin(Omega_rad*Time+Thet-2*pi/3) ParallelBranchesNum=1
  PhaseC: Winding Group Type=Current IsSolid=false Current=Imax*sin(Omega_rad*Time+Thet-4*pi/3) ParallelBranchesNum=1
  core loss on: Stator, Rotor
parameters:
  Torque1: Torque Coordinate_System=Global Is_Positive=true Objects=[PM19, PM2, PM4, PM6, PM8, PM10, PM12, PM14, PM16, PM18, PM20, PM1, PM3, PM5, PM7, PM9, PM11, PM13, PM15, PM17, Rotor]
mesh:
  Coils: LengthBased RefineInside Objects=[PhaseA1_neg, PhaseA1_pos, PhaseA2_neg, PhaseA2_pos, PhaseA3_neg, PhaseA3_pos, PhaseA4_neg, PhaseA4_pos, PhaseB1_neg, PhaseB1_pos, PhaseB2_neg, PhaseB2_pos, PhaseB3_neg, PhaseB3_pos, PhaseB4_neg, PhaseB4_pos, PhaseC1_neg, PhaseC1_pos, PhaseC2_neg, PhaseC2_pos, PhaseC3_neg, PhaseC3_pos, PhaseC4_neg, PhaseC4_pos] MaxLength=4mm
  Magnet_neg: LengthBased RefineInside Objects=[PM2, PM4, PM6, PM8, PM10, PM12, PM14, PM16, PM18, PM20] MaxLength=3mm
  Magnet_pos: LengthBased RefineInside Objects=[PM1, PM3, PM5, PM7, PM9, PM11, PM13, PM15, PM17, PM19] MaxLength=3mm
  Rotor: LengthBased RefineInside Objects=Rotor MaxLength=4mm
  Stator: LengthBased RefineInside Objects=Stator MaxLength=4mm
  initial mesh: MeshMethod=AnsoftTAU
setups:
  Setup1: Transient NonlinearSolverResidual=1e-06 StopTime=25ms TimeStep=100us SaveFieldsType=Custom SweepRanges{0ms to 50ms step 250us} NumberSolveSteps=1 RangeStart=0s RangeEnd=0.1s InitialTimeStep=0.002s MinTimeStep=0.001s MaxTimeStep=0.003s TimeStepErrTolerance=0.0001
reports:
  Winding Plot 1: InducedVoltage(PhaseA), InducedVoltage(PhaseB), InducedVoltage(PhaseC) vs Time on Setup1 : Transient [Imax=all]; markers m1 at 13.3ms
  Calculator Expressions Plot 1: Mag_B vs Distance on Setup1 : Transient [Time=1.85e+07ns Imax=all]
   Plot 1: InducedVoltage(PhaseA)-InducedVoltage(PhaseB), InducedVoltage(PhaseB)-InducedVoltage(PhaseC), InducedVoltage(PhaseC)-InducedVoltage(PhaseA) vs Time on Setup1 : Transient [Imax=all]
  Torque Plot 1: Torque vs Time on Setup1 : Transient
