# Ansys Electronics Desktop project, version 2020.1
materials:
  vacuum: permittivity=1
  N42_material_neg: CoordinateSystemType=Cylindrical permittivity=1 permeability=1.05 conductivity=625000 magnetic_coercivity{Magnitude=-1000402.5A_per_meter DirComp1=-1 DirComp2=0 DirComp3=0} lande_g_factor=2
  N42_material_pos: CoordinateSystemType=Cylindrical permittivity=1 permeability=1.05 conductivity=625000 magnetic_coercivity{Magnitude=-1000402.5A_per_meter DirComp1=1 DirComp2=0 DirComp3=0} lande_g_factor=2
  M19_29G: permeability{HUnit=A_per_meter BUnit=tesla curve (0, 0) (22.28, 0.05) (25.46, 0.1) (31.83, 0.15) (47.74, 0.36) (63.66, 0.54) (79.57, 0.65) (159.15, 0.99) (318.3, 1.2) (477.46, 1.28) (636.61, 1.33) (795.77, 1.36) (1591.5, 1.44) (3183, 1.52) (4774.6, 1.58) (6366.1, 1.63) (7957.7, 1.67) (15915, 1.8) (31830, 1.9) (111407, 2) (190984, 2.1) (350138, 2.3) (509292, 2.5)} conductivity=1960000 core_loss_type="Electrical Steel" core_loss_kh=164.2 core_loss_kc=0.409 mass_density=7650
  copper: permeability=0.999991 conductivity=58000000

design Maxwell2DDesign1 (Maxwell 2D, Transient, XY geometry, model units mm)
options: ModelDepth=1meter
variables:
  CurrentPeak = 2.5A
  NumberOfConductors = 1
  Omega_deg = 0
geometry:
  SlotCore1 [M19_29G] = user_primitive(RMxprt/SlotCore.dll, DiaGap=65.3mm, DiaYoke=160mm, Length=0mm, Skew=0deg, Slots=36, SlotType=4, Hs0=1mm, Hs01=0mm, Hs1=0mm, Hs2=16.6mm, Bs0=2.8mm, Bs1=2.8mm, Bs2=5.7mm, Rs=0mm, FilletType=1, HalfSlot=0, SegAngle=0deg, LenRegion=200mm, InfoCore=0)
  PMCore1 [M19_29G] = user_primitive(RMxprt/PMCore.dll, DiaGap=63.3mm, DiaYoke=0mm, Length=0mm, Poles=4, PoleType=1, Embrace=1, ThickMag=1.6mm, WidthMag=45mm, Offset=0mm, Bridge=2mm, Rib=3mm, LenRegion=200mm, InfoCore=0)
  PM4 [N42_material_pos] = user_primitive(RMxprt/PMCore.dll, DiaGap=63.3mm, DiaYoke=0mm, Length=0mm, Poles=4, PoleType=1, Embrace=0.999, ThickMag=1.6mm, WidthMag=45mm, Offset=0mm, Bridge=2mm, Rib=3mm, LenRegion=200mm, InfoCore=1)
  PM2 [N42_material_pos], PM3, PM1 [N42_material_neg] = PM4.separate_bodies()
  Circle1 [vacuum] = circle(normal=Z, centre=(0mm, 0mm, 0mm), radius=158.90249mm)
  Circle2 [vacuum] = circle(normal=Z, centre=(0mm, 0mm, 0mm), radius=32.159602mm)
  B_neg_1 [copper] = user_primitive(RMxprt/LapCoil.dll, DiaGap=61mm, DiaYoke=160mm, Length=0mm, Skew=0deg, Slots=36, SlotType=1, Hs0=1mm, Hs1=0mm, Hs2=16.6mm, Bs0=2.8mm, Bs1=2.8mm, Bs2=5.7mm, Rs=0mm, FilletType=0, Layers=1, CoilPitch=9, EndExt=5mm, SpanExt=0mm, BendAngle=0deg, SegAngle=10deg, LenRegion=200mm, InfoCoil=0)
  B1_pos_1, C2_pos, C1_neg, B2_pos_2, B_neg_2, C2_neg_1, C2_pos_1, A2_pos, A2_neg, C1_pos_2, C2_neg_2, A1_neg_1, A2_pos_1, B1_pos, B1_neg, A1_neg_2, A1_pos_2, C1_pos_1, C1_neg_1, B1_neg_2, B1_pos_2, C2_neg, C1_pos, B2_pos_1, B1_neg_1, A2_neg_2, A2_pos_2, B_neg, B2_pos, A1_pos_1, A2_neg_1, C1_neg_2, C2_pos_2, A1_neg, A1_pos [copper] = B_neg_1.separate_bodies()
  Band [vacuum] = circle(normal=Z, centre=(0mm, 0mm, 0mm), radius=31.835201mm)
  PMCore1.rotate(axis=Z, angle=Omega_deg)
motion:
  MotionSetup1: Band Move_Type=Rotate Coordinate_System=Global Axis=Z Is_Positive=true InitPos=0deg Angular_Velocity=1500rpm Objects=Band
  Moving1: Moving Objects=[PMCore1, PM4, PM2, PM3, PM1]
boundaries and excitations:
  VectorPotential1: Vector Potential Edges=Circle1.edge(1 of 1) Value=0
  A1_neg: Coil Objects=A1_neg Conductor_number=NumberOfConductors Winding=PhaseA_neg PolarityType=Negative
  A1_neg_1: Coil Objects=A1_neg_1 Conductor_number=NumberOfConductors Winding=PhaseA_neg PolarityType=Negative
  A1_neg_2: Coil Objects=A1_neg_2 Conductor_number=NumberOfConductors Winding=PhaseA_neg PolarityType=Negative
  A2_neg: Coil Objects=A2_neg Conductor_number=NumberOfConductors Winding=PhaseA_neg PolarityType=Negative
  A2_neg_1: Coil Objects=A2_neg_1 Conductor_number=NumberOfConductors Winding=PhaseA_neg PolarityType=Negative
  A2_neg_2: Coil Objects=A2_neg_2 Conductor_number=NumberOfConductors Winding=PhaseA_neg PolarityType=Negative
  A1_pos: Coil Objects=A1_pos Conductor_number=NumberOfConductors Winding=PhaseA_pos PolarityType=Positive
  A1_pos_1: Coil Objects=A1_pos_1 Conductor_number=NumberOfConductors Winding=PhaseA_pos PolarityType=Positive
  A1_pos_2: Coil Objects=A1_pos_2 Conductor_number=NumberOfConductors Winding=PhaseA_pos PolarityType=Positive
  A2_pos: Coil Objects=A2_pos Conductor_number=NumberOfConductors Winding=PhaseA_pos PolarityType=Positive
  A2_pos_1: Coil Objects=A2_pos_1 Conductor_number=NumberOfConductors Winding=PhaseA_pos PolarityType=Positive
  A2_pos_2: Coil Objects=A2_pos_2 Conductor_number=NumberOfConductors Winding=PhaseA_pos PolarityType=Positive
  B_neg: Coil Objects=B_neg Conductor_number=NumberOfConductors Winding=PhaseB_neg PolarityType=Negative
  B_neg_1: Coil Objects=B_neg_1 Conductor_number=NumberOfConductors Winding=PhaseB_neg PolarityType=Negative
  B_neg_2: Coil Objects=B_neg_2 Conductor_number=NumberOfConductors Winding=PhaseB_neg PolarityType=Negative
  B1_neg: Coil Objects=B1_neg Conductor_number=NumberOfConductors Winding=PhaseB_neg PolarityType=Negative
  B1_neg_1: Coil Objects=B1_neg_1 Conductor_number=NumberOfConductors Winding=PhaseB_neg PolarityType=Negative
  B1_neg_2: Coil Objects=B1_neg_2 Conductor_number=NumberOfConductors Winding=PhaseB_neg PolarityType=Negative
  B1_pos: Coil Objects=B1_pos Conductor_number=NumberOfConductors Winding=PhaseB_pos PolarityType=Positive
  B1_pos_1: Coil Objects=B1_pos_1 Conductor_number=NumberOfConductors Winding=PhaseB_pos PolarityType=Positive
  B1_pos_2: Coil Objects=B1_pos_2 Conductor_number=NumberOfConductors Winding=PhaseB_pos PolarityType=Positive
  B2_pos: Coil Objects=B2_pos Conductor_number=NumberOfConductors Winding=PhaseB_pos PolarityType=Positive
  B2_pos_1: Coil Objects=B2_pos_1 Conductor_number=NumberOfConductors Winding=PhaseB_pos PolarityType=Positive
  B2_pos_2: Coil Objects=B2_pos_2 Conductor_number=NumberOfConductors Winding=PhaseB_pos PolarityType=Positive
  C1_neg: Coil Objects=C1_neg Conductor_number=NumberOfConductors Winding=PhaseC_neg PolarityType=Negative
  C1_neg_1: Coil Objects=C1_neg_1 Conductor_number=NumberOfConductors Winding=PhaseC_neg PolarityType=Negative
  C1_neg_2: Coil Objects=C1_neg_2 Conductor_number=NumberOfConductors Winding=PhaseC_neg PolarityType=Negative
  C2_neg: Coil Objects=C2_neg Conductor_number=NumberOfConductors Winding=PhaseC_neg PolarityType=Negative
  C2_neg_1: Coil Objects=C2_neg_1 Conductor_number=NumberOfConductors Winding=PhaseC_neg PolarityType=Negative
  C2_neg_2: Coil Objects=C2_neg_2 Conductor_number=NumberOfConductors Winding=PhaseC_neg PolarityType=Negative
  C2_pos: Coil Objects=C2_pos Conductor_number=NumberOfConductors Winding=PhaseC_pos PolarityType=Positive
  C2_pos_1: Coil Objects=C2_pos_1 Conductor_number=NumberOfConductors Winding=PhaseC_pos PolarityType=Positive
  C2_pos_2: Coil Objects=C2_pos_2 Conductor_number=NumberOfConductors Winding=PhaseC_pos PolarityType=Positive
  C1_pos: Coil Objects=C1_pos Conductor_number=NumberOfConductors Winding=PhaseC_pos PolarityType=Positive
  C1_pos_1: Coil Objects=C1_pos_1 Conductor_number=NumberOfConductors Winding=PhaseC_pos PolarityType=Positive
  C1_pos_2: Coil Objects=C1_pos_2 Conductor_number=NumberOfConductors Winding=PhaseC_pos PolarityType=Positive
  PhaseA_pos: Winding Group Type=Current IsSolid=false Current=CurrentPeak*sin(Omega_deg*2*pi/360*Time) ParallelBranchesNum=1
  PhaseA_neg: Winding Group Type=Current IsSolid=false Current=-CurrentPeak*sin(Omega_deg*2*pi/360*Time) ParallelBranchesNum=1
  PhaseB_pos: Winding Group Type=Current IsSolid=false Current=CurrentPeak*sin(Omega_deg*2*pi/360-2*pi/3) ParallelBranchesNum=1
  PhaseB_neg: Winding Group Type=Current IsSolid=false Current=-CurrentPeak*sin(Omega_deg*2*pi/360-2*pi/3) ParallelBranchesNum=1
  PhaseC_pos: Winding Group Type=Current IsSolid=false Current=CurrentPeak*sin(Omega_deg*2*pi/360+2*pi/3) ParallelBranchesNum=1
  PhaseC_neg: Winding Group Type=Current IsSolid=false Current=-CurrentPeak*sin(Omega_deg*2*pi/360+2*pi/3) ParallelBranchesNum=1
mesh:
  initial mesh: MeshMethod=AnsoftTAU
setups:
  Setup1: Transient NonlinearSolverResidual=1e-06 StopTime=15ms TimeStep=250us SaveFieldsType=Custom SweepRanges{0ms to 15ms step 250us} NumberSolveSteps=1 RangeStart=0s RangeEnd=0.1s InitialTimeStep=0.002s MinTimeStep=0.001s MaxTimeStep=0.003s TimeStepErrTolerance=0.0001
