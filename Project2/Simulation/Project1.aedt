# Ansys Electronics Desktop project, version 2020.1
materials:
  vacuum: permittivity=1
  NdFe30: permittivity=1 permeability=1.044573 conductivity=625000 magnetic_coercivity{Magnitude=-838000A_per_meter DirComp1=1 DirComp2=0 DirComp3=0} lande_g_factor=2
  M19_29G: permeability{HUnit=A_per_meter BUnit=tesla curve (0, 0) (22.28, 0.05) (25.46, 0.1) (31.83, 0.15) (47.74, 0.36) (63.66, 0.54) (79.57, 0.65) (159.15, 0.99) (318.3, 1.2) (477.46, 1.28) (636.61, 1.33) (795.77, 1.36) (1591.5, 1.44) (3183, 1.52) (4774.6, 1.58) (6366.1, 1.63) (7957.7, 1.67) (15915, 1.8) (31830, 1.9) (111407, 2) (190984, 2.1) (350138, 2.3) (509292, 2.5)} conductivity=1960000 core_loss_type="Electrical Steel" core_loss_kh=164.2 core_loss_kc=0.409 mass_density=7650
  copper: permeability=0.999991 conductivity=58000000

design 1_whole_motor (Maxwell 2D, Transient, XY geometry, model units mm)
options: ModelDepth=1meter
geometry:
  Stator [vacuum] = user_primitive(RMxprt/SlotCore.dll, DiaGap=161.9mm, DiaYoke=269.24mm, Length=0mm, Skew=0deg, Slots=24, SlotType=1, Hs0=1.03mm, Hs01=0mm, Hs1=1mm, Hs2=29.5mm, Bs0=1.93mm, Bs1=5mm, Bs2=8mm, Rs=5mm, FilletType=0, HalfSlot=0, SegAngle=0deg, LenRegion=200mm, InfoCore=0)
  Rotor [vacuum] = user_primitive(RMxprt/PMCore.dll, DiaGap=160.4mm, DiaYoke=110.64mm, Length=0mm, Poles=20, PoleType=3, Embrace=0.7, ThickMag=6.48mm, WidthMag=32mm, Offset=0mm, Bridge=5mm, Rib=1mm, LenRegion=200mm, InfoCore=0)
  Magnets [vacuum] = user_primitive(RMxprt/PMCore.dll, DiaGap=160.4mm, DiaYoke=110.64mm, Length=0mm, Poles=20, PoleType=3, Embrace=0.7, ThickMag=6.48mm, WidthMag=32mm, Offset=0mm, Bridge=5mm, Rib=1mm, LenRegion=200mm, InfoCore=1)
  PhaseA1 [vacuum] = user_primitive(RMxprt/LapCoil.dll, DiaGap=161.9mm, DiaYoke=269.24mm, Length=0mm, Skew=0deg, Slots=24, SlotType=2, Hs0=1.28mm, Hs1=0.1mm, Hs2=29.7mm, Bs0=2.11mm, Bs1=3.14mm, Bs2=5.65mm, Rs=2.5mm, FilletType=0, Layers=1, CoilPitch=1, EndExt=5mm, SpanExt=18mm, BendAngle=0deg, SegAngle=10deg, LenRegion=200mm, InfoCoil=1)
  PhaseC1, PhaseB1 [vacuum] = PhaseA1.duplicate_around_axis(axis=Z, angle=30deg, total=3)
  PhaseA1_1, PhaseA1_2, PhaseA1_3 [vacuum] = PhaseA1.duplicate_around_axis(axis=Z, angle=90deg, total=4)
  PhaseB1_1, PhaseB1_2, PhaseB1_3 [vacuum] = PhaseB1.duplicate_around_axis(axis=Z, angle=90deg, total=4)
  PhaseC1_1, PhaseC1_2, PhaseC1_3 [vacuum] = PhaseC1.duplicate_around_axis(axis=Z, angle=90deg, total=4)
mesh:
  initial mesh: MeshMethod=AnsoftTAU

design 2_partial_motor (Maxwell 2D, Transient, XY geometry, model units mm)
options: ModelDepth=1meter
geometry:
  Stator [M19_29G] = user_primitive(RMxprt/SlotCore.dll, DiaGap=161.9mm, DiaYoke=269.24mm, Length=0mm, Skew=0deg, Slots=24, SlotType=1, Hs0=1.03mm, Hs01=0mm, Hs1=1mm, Hs2=29.5mm, Bs0=1.93mm, Bs1=5mm, Bs2=8mm, Rs=5mm, FilletType=0, HalfSlot=0, SegAngle=0deg, LenRegion=200mm, InfoCore=0)
  Rotor [M19_29G] = user_primitive(RMxprt/PMCore.dll, DiaGap=160.4mm, DiaYoke=110.64mm, Length=0mm, Poles=20, PoleType=3, Embrace=0.7, ThickMag=6.48mm, WidthMag=32mm, Offset=0mm, Bridge=5mm, Rib=1mm, LenRegion=200mm, InfoCore=0)
  PM4 [vacuum] = user_primitive(RMxprt/PMCore.dll, DiaGap=160.4mm, DiaYoke=110.64mm, Length=0mm, Poles=20, PoleType=3, Embrace=0.7, ThickMag=6.48mm, WidthMag=32mm, Offset=0mm, Bridge=5mm, Rib=1mm, LenRegion=200mm, InfoCore=1)
  PhaseA1 [vacuum] = user_primitive(RMxprt/LapCoil.dll, DiaGap=161.9mm, DiaYoke=269.24mm, Length=0mm, Skew=0deg, Slots=24, SlotType=2, Hs0=1.28mm, Hs1=0.1mm, Hs2=29.7mm, Bs0=2.11mm, Bs1=3.14mm, Bs2=5.65mm, Rs=2.5mm, FilletType=0, Layers=1, CoilPitch=1, EndExt=5mm, SpanExt=18mm, BendAngle=0deg, SegAngle=10deg, LenRegion=200mm, InfoCoil=1)
  PhaseC1, PhaseB1 [vacuum] = PhaseA1.duplicate_around_axis(axis=Z, angle=30deg, total=3)
  [PM4, Stator, Rotor, PhaseA1, PhaseC1, PhaseB1].split(plane=ZX, keep=PositiveOnly)
  [PM4, Stator, Rotor, PhaseA1, PhaseC1, PhaseB1].split(plane=YZ, keep=PositiveOnly)
  Region [vacuum] = polyline((0mm, 0mm, 0mm) (200mm, 0mm, 0mm))
  Region.sweep_around_axis(axis=Z, angle=90deg, segments=10)
  PM2 [NdFe30, oriented by PM2_CS], PM3, PM5 [vacuum], PM1 [NdFe30, oriented by PM1_CS] = PM4.separate_bodies()
  coordinate_system PM1_CS = face of PM1: Origin=PM4.vertex(78 of 80) FaceID=PM4.face(at (76.2531, 12.0773, 0)) AxisPosn=PM4.vertex(79 of 80) WhichAxis=X ZRotationAngle=0deg XOffset=0mm YOffset=0mm
  coordinate_system PM2_CS = face of PM2: Origin=PM4.vertex(38 of 80) FaceID=PM4.face(at (68.7889, 35.0497, 0)) AxisPosn=PM4.vertex(39 of 80) WhichAxis=X ZRotationAngle=0deg XOffset=0mm YOffset=0mm
boundaries and excitations:
  Master1: Master Edges=Region.edge(1 of 1)
  Slave1: Slave Edges=Region.edge(#2284) ReverseU master=Master1 SameAsMaster=false
  Zero_Flux: Vector Potential Edges=Region.edge(#2283, #2282, #2281, #2280, #2279, #2278, #2277, #2276, #2275, #2274, #2273) Value=0
mesh:
  initial mesh: MeshMethod=AnsoftTAU

design 3_partial_motor_MS (Maxwell 2D, Magnetostatic, XY geometry, model units mm)
geometry:
  Stator [M19_29G] = user_primitive(RMxprt/SlotCore.dll, DiaGap=161.9mm, DiaYoke=269.24mm, Length=0mm, Skew=0deg, Slots=24, SlotType=1, Hs0=1.03mm, Hs01=0mm, Hs1=1mm, Hs2=29.5mm, Bs0=1.93mm, Bs1=5mm, Bs2=8mm, Rs=5mm, FilletType=0, HalfSlot=0, SegAngle=0deg, LenRegion=200mm, InfoCore=0)
  Rotor [M19_29G] = user_primitive(RMxprt/PMCore.dll, DiaGap=160.4mm, DiaYoke=110.64mm, Length=0mm, Poles=20, PoleType=3, Embrace=0.7, ThickMag=6.48mm, WidthMag=32mm, Offset=0mm, Bridge=5mm, Rib=1mm, LenRegion=200mm, InfoCore=0)
  PM4 [vacuum] = user_primitive(RMxprt/PMCore.dll, DiaGap=160.4mm, DiaYoke=110.64mm, Length=0mm, Poles=20, PoleType=3, Embrace=0.7, ThickMag=6.48mm, WidthMag=32mm, Offset=0mm, Bridge=5mm, Rib=1mm, LenRegion=200mm, InfoCore=1)
  PhaseA1 [vacuum] = user_primitive(RMxprt/LapCoil.dll, DiaGap=161.9mm, DiaYoke=269.24mm, Length=0mm, Skew=0deg, Slots=24, SlotType=2, Hs0=1.28mm, Hs1=0.1mm, Hs2=29.7mm, Bs0=2.11mm, Bs1=3.14mm, Bs2=5.65mm, Rs=2.5mm, FilletType=0, Layers=1, CoilPitch=1, EndExt=5mm, SpanExt=18mm, BendAngle=0deg, SegAngle=10deg, LenRegion=200mm, InfoCoil=1)
  PhaseC1, PhaseB1 [vacuum] = PhaseA1.duplicate_around_axis(axis=Z, angle=30deg, total=3)
  [PM4, Stator, Rotor, PhaseA1, PhaseC1, PhaseB1].split(plane=ZX, keep=PositiveOnly)
  [PM4, Stator, Rotor, PhaseA1, PhaseC1, PhaseB1].split(plane=YZ, keep=PositiveOnly)
  Region [vacuum] = polyline((0mm, 0mm, 0mm) (200mm, 0mm, 0mm))
  Region.sweep_around_axis(axis=Z, angle=90deg, segments=10)
  PM2 [NdFe30, oriented by PM2_CS], PM3, PM5 [vacuum], PM1 [NdFe30, oriented by PM1_CS] = PM4.separate_bodies()
  coordinate_system PM1_CS = face of PM1: Origin=PM4.vertex(78 of 80) FaceID=PM4.face(at (76.2531, 12.0773, 0)) AxisPosn=PM4.vertex(79 of 80) WhichAxis=X ZRotationAngle=0deg XOffset=0mm YOffset=0mm
  coordinate_system PM2_CS = face of PM2: Origin=PM4.vertex(38 of 80) FaceID=PM4.face(at (68.7889, 35.0497, 0)) AxisPosn=PM4.vertex(39 of 80) WhichAxis=X ZRotationAngle=0deg XOffset=0mm YOffset=0mm
boundaries and excitations:
  Master1: Master Edges=Region.edge(1 of 1)
  Slave1: Slave Edges=Region.edge(#2284) ReverseU master=Master1 SameAsMaster=false
  Zero_Flux: Vector Potential Edges=Region.edge(#2283, #2282, #2281, #2280, #2279, #2278, #2277, #2276, #2275, #2274, #2273) Value=0
parameters:
  Torque1: Torque Coordinate_System=Global Is_Positive=true Objects=[PM1, PM2, Rotor]
mesh:
  Rotor: LengthBased RefineInside Objects=Rotor MaxLength=5mm
  Length1: LengthBased RefineInside Objects=[PM1, PM2] MaxLength=3mm
  SurfApprox1: SurfApproxBased Objects=Stator CurvedSurfaceApproxChoice=UseSlider SliderMeshSettings=6
  initial mesh: MeshMethod=AnsoftTAU
setups:
  Setup1: Magnetostatic MaximumPasses=10 MinimumPasses=2 MinimumConvergedPasses=1 PercentRefinement=15 PercentError=0.1 ConstantDelta=0s NonLinearResidual=0.0001

design 4_partial_motor_MS2 (Maxwell 2D, Magnetostatic, XY geometry, model units mm)
geometry:
  Stator [M19_29G] = user_primitive(RMxprt/SlotCore.dll, DiaGap=161.9mm, DiaYoke=269.24mm, Length=0mm, Skew=0deg, Slots=24, SlotType=1, Hs0=1.03mm, Hs01=0mm, Hs1=1mm, Hs2=29.5mm, Bs0=1.93mm, Bs1=5mm, Bs2=8mm, Rs=5mm, FilletType=0, HalfSlot=0, SegAngle=0deg, LenRegion=200mm, InfoCore=0)
  Rotor [M19_29G] = user_primitive(RMxprt/PMCore.dll, DiaGap=160.4mm, DiaYoke=110.64mm, Length=0mm, Poles=20, PoleType=3, Embrace=0.7, ThickMag=6.48mm, WidthMag=32mm, Offset=0mm, Bridge=5mm, Rib=1mm, LenRegion=200mm, InfoCore=0)
  PM4 [vacuum] = user_primitive(RMxprt/PMCore.dll, DiaGap=160.4mm, DiaYoke=110.64mm, Length=0mm, Poles=20, PoleType=3, Embrace=0.7, ThickMag=6.48mm, WidthMag=32mm, Offset=0mm, Bridge=5mm, Rib=1mm, LenRegion=200mm, InfoCore=1)
  PhaseA1_neg [copper] = user_primitive(RMxprt/LapCoil.dll, DiaGap=161.9mm, DiaYoke=269.24mm, Length=0mm, Skew=0deg, Slots=24, SlotType=2, Hs0=1.28mm, Hs1=0.1mm, Hs2=29.7mm, Bs0=2.11mm, Bs1=3.14mm, Bs2=5.65mm, Rs=2.5mm, FilletType=0, Layers=1, CoilPitch=1, EndExt=5mm, SpanExt=18mm, BendAngle=0deg, SegAngle=10deg, LenRegion=200mm, InfoCoil=1)
  PhaseC1_pos, PhaseB1_neg [copper] = PhaseA1_neg.duplicate_around_axis(axis=Z, angle=30deg, total=3)
  [PM4, Stator, Rotor, PhaseA1_neg, PhaseC1_pos, PhaseB1_neg].split(plane=ZX, keep=PositiveOnly)
  [PM4, Stator, Rotor, PhaseA1_neg, PhaseC1_pos, PhaseB1_neg].split(plane=YZ, keep=PositiveOnly)
  Region [vacuum] = polyline((0mm, 0mm, 0mm) (200mm, 0mm, 0mm))
  Region.sweep_around_axis(axis=Z, angle=90deg, segments=10)
  PM2 [NdFe30, oriented by PM2_CS], PM3, PM5 [vacuum], PM1 [NdFe30, oriented by PM1_CS] = PM4.separate_bodies()
  coordinate_system PM1_CS = face of PM1: Origin=PM4.vertex(78 of 80) FaceID=PM4.face(at (76.2531, 12.0773, 0)) AxisPosn=PM4.vertex(79 of 80) WhichAxis=X ZRotationAngle=0deg XOffset=0mm YOffset=0mm
  coordinate_system PM2_CS = face of PM2: Origin=PM4.vertex(38 of 80) FaceID=PM4.face(at (68.7889, 35.0497, 0)) AxisPosn=PM4.vertex(39 of 80) WhichAxis=X ZRotationAngle=0deg XOffset=0mm YOffset=0mm
  PhaseA1_pos [copper] = PhaseA1_neg.separate_bodies()
  PhaseC1_neg [copper] = PhaseC1_pos.separate_bodies()
  PhaseB1_pos [copper] = PhaseB1_neg.separate_bodies()
boundaries and excitations:
  Master1: Master Edges=Region.edge(1 of 1)
  Slave1: Slave Edges=Region.edge(#2284) ReverseU master=Master1 SameAsMaster=false
  Zero_Flux: Vector Potential Edges=Region.edge(#2283, #2282, #2281, #2280, #2279, #2278, #2277, #2276, #2275, #2274, #2273) Value=0
  phasea_pos: Current Objects=PhaseA1_pos Current=500A IsPositive=true
  phasea_neg: Current Objects=PhaseA1_neg Current=500A IsPositive=false
  phasec_pos: Current Objects=PhaseC1_pos Current=-250A IsPositive=true
  phasec_neg: Current Objects=PhaseC1_neg Current=-250A IsPositive=false
  phaseb_neg: Current Objects=PhaseB1_neg Current=-250A IsPositive=false
  phaseb_pos: Current Objects=PhaseB1_pos Current=-250A IsPositive=true
parameters:
  Torque1: Torque Coordinate_System=Global Is_Positive=true Objects=[PM1, PM2, Rotor]
  Matrix1: Matrix phasea_neg, phasea_pos, phaseb_neg, phaseb_pos, phasec_neg, phasec_pos: NumberOfTurns=9; group phasea = phasea_neg, phasea_pos (1 parallel); group phaseb = phasec_neg, phasec_pos (1 parallel); group phasec = phaseb_neg, phaseb_pos (1 parallel)
mesh:
  Rotor: LengthBased RefineInside Objects=Rotor MaxLength=5mm
  Length1: LengthBased RefineInside Objects=[PM1, PM2] MaxLength=3mm
  SurfApprox1: SurfApproxBased Objects=Stator CurvedSurfaceApproxChoice=UseSlider SliderMeshSettings=6
  initial mesh: MeshMethod=AnsoftTAU
setups:
  Setup1: Magnetostatic MaximumPasses=10 MinimumPasses=2 MinimumConvergedPasses=1 PercentRefinement=15 PercentError=0.1 NonLinearResidual=0.0001

design 5_partial_motor_TR (Maxwell 2D, Transient, XY geometry, model units mm)
options: ModelDepth=1meter
variables:
  Poles = 20
  PolePairs = Poles/2
  Speed_rpm = 500
  Omega = 360*Speed_rpm*PolePairs/60
  Omega_rad = Omega*pi/180
  Thet_deg = 20
  Thet = Thet_deg*pi/180
  Imax = 250A
geometry:
  Stator [M19_29G] = user_primitive(RMxprt/SlotCore.dll, DiaGap=161.9mm, DiaYoke=269.24mm, Length=0mm, Skew=0deg, Slots=24, SlotType=1, Hs0=1.03mm, Hs01=0mm, Hs1=1mm, Hs2=29.5mm, Bs0=1.93mm, Bs1=5mm, Bs2=8mm, Rs=5mm, FilletType=0, HalfSlot=0, SegAngle=0deg, LenRegion=200mm, InfoCore=0)
  Rotor [M19_29G] = user_primitive(RMxprt/PMCore.dll, DiaGap=160.4mm, DiaYoke=110.64mm, Length=0mm, Poles=20, PoleType=3, Embrace=0.7, ThickMag=6.48mm, WidthMag=32mm, Offset=0mm, Bridge=5mm, Rib=1mm, LenRegion=200mm, InfoCore=0)
  PM4 [vacuum] = user_primitive(RMxprt/PMCore.dll, DiaGap=160.4mm, DiaYoke=110.64mm, Length=0mm, Poles=20, PoleType=3, Embrace=0.7, ThickMag=6.48mm, WidthMag=32mm, Offset=0mm, Bridge=5mm, Rib=1mm, LenRegion=200mm, InfoCore=1)
  PhaseA1_neg [vacuum] = user_primitive(RMxprt/LapCoil.dll, DiaGap=161.9mm, DiaYoke=269.24mm, Length=0mm, Skew=0deg, Slots=24, SlotType=2, Hs0=1.28mm, Hs1=0.1mm, Hs2=29.7mm, Bs0=2.11mm, Bs1=3.14mm, Bs2=5.65mm, Rs=2.5mm, FilletType=0, Layers=1, CoilPitch=1, EndExt=5mm, SpanExt=18mm, BendAngle=0deg, SegAngle=10deg, LenRegion=200mm, InfoCoil=1)
  PhaseC1_pos, PhaseB1_neg [vacuum] = PhaseA1_neg.duplicate_around_axis(axis=Z, angle=30deg, total=3)
  [PM4, Stator, Rotor, PhaseA1_neg, PhaseC1_pos, PhaseB1_neg].split(plane=ZX, keep=PositiveOnly)
  [PM4, Stator, Rotor, PhaseA1_neg, PhaseC1_pos, PhaseB1_neg].split(plane=YZ, keep=PositiveOnly)
  Region [vacuum] = polyline((0mm, 0mm, 0mm) (200mm, 0mm, 0mm))
  Region.sweep_around_axis(axis=Z, angle=90deg, segments=10)
  PM2 [NdFe30, oriented by PM2_CS], PM3, PM5 [vacuum], PM1 [NdFe30, oriented by PM1_CS] = PM4.separate_bodies()
  coordinate_system PM1_CS = face of PM1: Origin=PM4.vertex(78 of 80) FaceID=PM4.face(at (76.2531, 12.0773, 0)) AxisPosn=PM4.vertex(79 of 80) WhichAxis=X ZRotationAngle=0deg XOffset=0mm YOffset=0mm
  coordinate_system PM2_CS = face of PM2: Origin=PM4.vertex(38 of 80) FaceID=PM4.face(at (68.7889, 35.0497, 0)) AxisPosn=PM4.vertex(39 of 80) WhichAxis=X ZRotationAngle=0deg XOffset=0mm YOffset=0mm
  PhaseA1_pos [vacuum] = PhaseA1_neg.separate_bodies()
  PhaseC1_neg [vacuum] = PhaseC1_pos.separate_bodies()
  PhaseB1_pos [vacuum] = PhaseB1_neg.separate_bodies()
boundaries and excitations:
  Master1: Master Edges=Region.edge(1 of 1)
  Slave1: Slave Edges=Region.edge(#2284) ReverseU master=Master1 SameAsMaster=false
  Zero_Flux: Vector Potential Edges=Region.edge(#2283, #2282, #2281, #2280, #2279, #2278, #2277, #2276, #2275, #2274, #2273) Value=0
  PhaseA1_neg: Coil Objects=PhaseA1_neg Conductor_number=9 Winding=-1 PolarityType=Negative
  PhaseA1_pos: Coil Objects=PhaseA1_pos Conductor_number=9 Winding=-1 PolarityType=Positive
  PhaseB1_neg: Coil Objects=PhaseB1_neg Conductor_number=9 Winding=-1 PolarityType=Negative
  PhaseC1_neg: Coil Objects=PhaseC1_neg Conductor_number=9 Winding=-1 PolarityType=Negative
  PhaseC1_pos: Coil Objects=PhaseC1_pos Conductor_number=9 Winding=-1 PolarityType=Positive
  PhaseB1_pos: Coil Objects=PhaseB1_pos Conductor_number=9 Winding=-1 PolarityType=Positive
mesh:
  initial mesh: MeshMethod=AnsoftTAU
