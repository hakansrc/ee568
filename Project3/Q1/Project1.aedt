# Ansys Electronics Desktop project, version 2020.1
materials:
  vacuum: permittivity=1
  N42_material_pos: CoordinateSystemType=Cylindrical permittivity=1 permeability=1.05 conductivity=625000 magnetic_coercivity{Magnitude=-1000402.5A_per_meter DirComp1=1 DirComp2=0 DirComp3=0} lande_g_factor=2
  M19_29G: permeability{HUnit=A_per_meter BUnit=tesla curve (0, 0) (22.28, 0.05) (25.46, 0.1) (31.83, 0.15) (47.74, 0.36) (63.66, 0.54) (79.57, 0.65) (159.15, 0.99) (318.3, 1.2) (477.46, 1.28) (636.61, 1.33) (795.77, 1.36) (1591.5, 1.44) (3183, 1.52) (4774.6, 1.58) (6366.1, 1.63) (7957.7, 1.67) (15915, 1.8) (31830, 1.9) (111407, 2) (190984, 2.1) (350138, 2.3) (509292, 2.5)} conductivity=1960000 core_loss_type="Electrical Steel" core_loss_kh=164.2 core_loss_kc=0.409 mass_density=7650
  N42_material_neg: CoordinateSystemType=Cylindrical permittivity=1 permeability=1.05 conductivity=625000 magnetic_coercivity{Magnitude=-1000402.5A_per_meter DirComp1=-1 DirComp2=0 DirComp3=0} lande_g_factor=2

design Maxwell2DDesign1 (Maxwell 2D, Magnetostatic, XY geometry, model units mm)
geometry:
  Stator [M19_29G] = user_primitive(RMxprt/PMCore.dll, DiaGap=150mm, DiaYoke=105mm, Length=0mm, Poles=4, PoleType=1, Embrace=0.7, ThickMag=0mm, WidthMag=251.3274mm, Offset=0mm, Bridge=2mm, Rib=3mm, LenRegion=200mm, InfoCore=0)
  Rotor [M19_29G] = user_primitive(RMxprt/PMCore.dll, DiaGap=108mm, DiaYoke=0mm, Length=0mm, Poles=4, PoleType=1, Embrace=0.7, ThickMag=4mm, WidthMag=(pi*0.1*0.8*1000) mm, Offset=0mm, Bridge=2mm, Rib=3mm, LenRegion=200mm, InfoCore=0)
  PM4 [N42_material_pos] = user_primitive(RMxprt/PMCore.dll, DiaGap=104mm, DiaYoke=0mm, Length=0mm, Poles=4, PoleType=1, Embrace=0.7, ThickMag=2mm, WidthMag=45mm, Offset=0mm, Bridge=2mm, Rib=3mm, LenRegion=200mm, InfoCore=1)
  PM2 [N42_material_pos], PM3 [N42_material_neg], PM1 [N42_material_pos] = PM4.separate_bodies()
  Circle1 [vacuum] = circle(normal=Z, centre=(0mm, 0mm, 0mm), radius=145mm)
  Circle2 [vacuum, non-model] = circle(normal=Z, centre=(0mm, 0mm, 0mm), radius=52.25mm)
boundaries and excitations:
  VectorPotential1: Vector Potential Edges=Circle1.edge(1 of 1) Value=0
mesh:
  initial mesh: MeshMethod=AnsoftTAU
setups:
  Setup1: Magnetostatic MaximumPasses=10 MinimumPasses=2 MinimumConvergedPasses=1 PercentRefinement=15 PercentError=0.1 NonLinearResidual=1e-05
field calculator expressions:
  line = Mag_B | EnterLine(Circle2) | LineValue | Integrate
reports:
   Plot 1: Mag_B vs Distance on Setup1 : LastAdaptive; markers m1 at 122.4559mm
